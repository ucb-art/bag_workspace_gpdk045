ADE simulation setup
Run mode: Single Run, Sweeps and Corners
Tests:
  tb_ac: ee240b_hw3/folded_cascode/schematic, simulator spectre
    Outputs: bw_3db
Global variables:
  cload = 60f
  vdd = 1.2
  vincm = 0.6
  vnbot = 0.6958
  vntop = 0.7643
  vpbot = 0.5238
  vptop = 0.3776
  voutcm = 0.6
