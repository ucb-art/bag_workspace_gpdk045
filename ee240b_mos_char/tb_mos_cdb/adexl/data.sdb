ADE simulation setup
Run mode: Single Run, Sweeps and Corners
Tests:
  ee240b_mos_char:tb_mos_cdb:1: ee240b_mos_char/tb_mos_cdb/schematic, simulator spectre
    Outputs: bw
Global variables:
  nf = {From/To}Linear:2:10:100{From/To}
  vgs = 0.6
