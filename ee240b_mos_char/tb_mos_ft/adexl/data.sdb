ADE simulation setup
Run mode: Single Run, Sweeps and Corners
Tests:
  ee240b_mos_char:tb_mos_ft:1: ee240b_mos_char/tb_mos_ft/schematic, simulator spectre
Global variables:
  vds = 0.6
  vgs = 0.6
