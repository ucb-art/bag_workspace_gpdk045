ADE simulation setup
Run mode: Single Run, Sweeps and Corners
Tests:
  ee240b_mos_char:tb_mos_ibias:1: ee240b_mos_char/tb_mos_ibias/schematic, simulator spectre
Global variables:
  vds = {From/To}Linear:0:0.05:1.2{From/To}
  vgs = 0.6
  vgs_start = 0
  vgs_stop = 1.2
