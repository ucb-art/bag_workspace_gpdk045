ADE simulation setup
Run mode: Single Run, Sweeps and Corners
Tests:
  tb_ac_noise: ee240b_hw2/cascode_tb_ac_noise/schematic, simulator spectre
    Outputs: fbw; vout_noise; integ((getData("out" ?result 'noise)**2) 1.4e+09 1.6e+09 " "); vout_var_bw; gain; snr_den
Global variables:
  cload = 10f
  seg_in = 505
  seg_load = 532
  seg_tail = 1010
  vdd = 1.2
  vincm = 0.4835
  voutcm = 0.6
  vtail = 1.2-0.5402
  in_scale = 2
  load_scale = 1
  vcasn = 1.1
  vcasp = 0.3872
  vinacdc = 0
Corners (nominal off):
  model folders: /home/ff/ee240b/sp18/gpdk/gpdk045_v_5_0/models/spectre
  tt: temperature=25; gpdk045.scs[tt]
  ff (off): temperature=70; gpdk045.scs[ff]
  ss (off): temperature=0; gpdk045.scs[ss]
  sf (off): temperature=25; gpdk045.scs[sf]
  fs (off): temperature=25; gpdk045.scs[fs]
