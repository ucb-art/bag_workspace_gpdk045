ADE simulation setup
Run mode: Single Run, Sweeps and Corners
Tests:
  ee240b_hw2:cascode_test:1: ee240b_hw2/cascode_test/schematic, simulator spectre
Global variables:
  in_scale = 1
  load_scale = 4
  seg_in = 398
  seg_load = 49
  vcasn = 0.6
  vcasp = 0.4
  vdd = 1.2
  vincm = 0.4552
