ADE simulation setup
Run mode: Single Run, Sweeps and Corners
Tests:
  noise: ee240b_hw2/noise_test/schematic, simulator spectre
Global variables:
  vds = 0.5
  vgs = 0.5
  nf = 20
  lch = 45n 90n 180n 360n
