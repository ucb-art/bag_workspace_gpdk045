ADE simulation setup
Run mode: Single Run, Sweeps and Corners
Tests:
  tb_ac_noise: ee240b_hw2/diffamp_tb_ac_noise/schematic, simulator spectre
    Outputs: fbw; vout_noise; vout_var_tot; integ((getData("out" ?result 'noise)**2) 1.4e+09 1.6e+09 " "); vout_var_bw; gain; snr_tot; snr_den
Global variables:
  cload = 9.464e-14
  seg_in = 336
  seg_load = 55
  seg_tail = 672
  vdd = 1.2
  vincm = 0.3229
  voutcm = 0.6
  vtail = 1.2-0.6743
Corners (nominal off):
  model folders: /home/ff/ee240b/sp18/gpdk/gpdk045_v_5_0/models/spectre
  tt: temperature=25; gpdk045.scs[tt]
  ff (off): temperature=70; gpdk045.scs[ff]
  ss (off): temperature=0; gpdk045.scs[ss]
  sf (off): temperature=25; gpdk045.scs[sf]
  fs (off): temperature=25; gpdk045.scs[fs]
