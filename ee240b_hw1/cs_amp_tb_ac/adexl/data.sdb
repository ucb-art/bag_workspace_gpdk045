ADE simulation setup
Run mode: Single Run, Sweeps and Corners
Tests:
  ee240b_hw1:cs_amp_tb_ac:1: ee240b_hw1/cs_amp_tb_ac/schematic, simulator spectre
    Outputs: ibias; voutdc; gain; bw
Global variables:
  cload = 50e-15
  nf = 36
  rload = 689.07
  vdd = 1.2
  vgs = 0.45171
