ADE simulation setup
Run mode: Single Run, Sweeps and Corners
Tests:
  ac: ee240b_prj_phase1/tia_char2/schematic, simulator spectre
    Outputs: bw; rdc
Global variables:
  ci = 142.1f
  cl = 65.8f
  iamp = 1
  rf = 4305.9
  gm = 26.1m
  ro = 625.4
  cgd = 9.58f
