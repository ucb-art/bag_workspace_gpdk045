ADE simulation setup
Run mode: Single Run, Sweeps and Corners
Tests:
  ac: ee240b_prj_phase1/tia_char/schematic, simulator spectre
    Outputs: bw; rdc
Global variables:
  ci = 20f
  cl = 40f
  iamp = 1
  rf = 11068
  vdd = 1.2
